SUPEROPAMP_PSPICE_FROM_TINA (PSpice format with ADA4817-1)
**************************************
**  This file was created by TINA   **
**  Updated to high-speed ADA4817-1 **
**************************************
.TEMP 27
.AC DEC 1250 1 100MEG
.TRAN 2N 1U
.DC LIN Vin -150U 150U 30N

.OPTIONS ABSTOL=1P ITL1=150 ITL2=20 ITL4=10 TRTOL=7
.PROBE V(3,4) V(5,6) V([in]) V([out])

Vin         in 0 DC 0 AC 1 0
+ PULSE ( 0 1 0  0  0  1e19 1e20 )
V3          cc 0 20
V2          0 dd 20
C6          0 8 8P
C5          9 out 8P
C4          11 6 1.6P
C3          5 12 1.6P
C2          13 4 1.6P
C1          3 14 1.6P
R10         6 8 750
R9          8 0 15K
R8          5 9 750
R7          9 out 15K
XOP5         8 9 cc dd out ADA4817_5PIN
R6          12 11 500
R5          6 11 49.5K
R4          5 12 49.5K
XOP4         4 11 cc dd 6 ADA4817_5PIN
XOP3         3 12 cc dd 5 ADA4817_5PIN
R3          14 13 500
R2          4 13 49.5K
R1          3 14 49.5K
XOP2         in 13 cc dd 4 ADA4817_5PIN
XOP1         0 14 cc dd 3 ADA4817_5PIN

* ----------------------------------------------------------------------
* 5-PIN WRAPPER FOR ADA4817 SPICE MACROMODEL
* ----------------------------------------------------------------------
.subckt ADA4817_5PIN vp vn vcc vee out
* Mapea el macromodelo de 7 pines del fabricante a una interfaz estándar de 5 pines
* vp=100, vn=101, vcc=102, vee=103, out=104, FB=105, PD=106
* Conectamos FB a out, y habilitamos permanentemente el chip conectando PD a vcc
XADA vp vn vcc vee out out vcc ADA4817
.ends ADA4817_5PIN

* ----------------------------------------------------------------------
* OFFICIAL ADA4817 MACROMODEL DEFINITION
* ----------------------------------------------------------------------
.Subckt ADA4817 100 101 102 103 104 105 106
Rz1	102	1020	Rideal	1e-6
Rz2	103	1030	Rideal	1e-6
Ibias	1020	1030	dc	1.5e-3
DzPS	98	1020	diode
Iquies	1020	98	dc	17.5e-3
S1	98	1030	106	113	Switch
R1	1020	99	Rideal	1e7
R2	99	1030	Rideal	1e7
e1	111	110	1020	110	1
e2	110	112	110	1030	1
e3	110	0	99	0	1
S2	1	100	106	113	Switch
S3	9	101	106	113	Switch
VOS	1	2	dc	0
IbiasP	110	2	dc	2e-12
IbiasN	110	9	dc	2e-12
RinCMP	110	2	Rideal	500000e6
RinCMN	9	110	Rideal	500000e6
CinCMP	110	2	1.3e-12
CinCMN	9	110	1.3e-12
IOS	9	2	1e-12
RinDiff	9	2	Rideal	5000e3
CinDiff	9	2	0.3e-12
g1	3	110	110	2	0.001
RInP	3	110	Rideal	1e3
RX1	40	3	Rideal	0.001
DInP	40	41	diode
DInN	42	40	diode
VinP	111	41	dc	3.26
VinN	42	112	dc	0.46
hVn	6	5	Vmeas1	707.10678
Vmeas1	20	110	DC	0
Vvn	21	110	dc	0.65
Dvn	21	20	DVnoisy
hVn1	6	7	Vmeas2	707.10678
Vmeas2	22	110	dc	0
Vvn1	23	110	dc	0.65
Dvn1	23	22	DVnoisy
FnIN	9	110	Vmeas3	0.7071068
Vmeas3	51	110	dc	0
VnIN	50	110	dc	0.65
DnIN	50	51	DINnoisy
FnIN1	110	9	Vmeas4	0.7071068
Vmeas4	53	110	dc	0
VnIN1	52	110	dc	0.65
DnIN1	52	53	DINnoisy
FnIP	2	110	Vmeas5	0.7071068
Vmeas5	31	110	dc	0
VnIP	30	110	dc	0.65
DnIP	30	31	DIPnoisy
FnIP1	110	2	Vmeas6	0.7071068
Vmeas6	33	110	dc	0
VnIP1	32	110	dc	0.65
DnIP1	32	33	DIPnoisy
RcmrrP	3	10	Rideal	1e12
RcmrrN	10	9	Rideal	1e12
g10	11	110	10	110	-1e-10
Lcmrr	11	12	1e-12
Rcmrr	12	110	Rideal	1e3
e4	5	3	11	110	1
VPD	111	80	dc	3
VPD1	81	0	dc	2
RPD	111	106	Rideal	1e6
ePD	80	113	82	0	1
RDP1	82	0	Rideal	1e3
CPD	82	0	1e-10
S5	81	82	83	113	Switch
CDP1	83	0	1e-12
RPD2	106	83	1e6
RF	105	104	Rideal	0.001
g200	200	110	7	9	1
R200	200	110	Rideal	250
DzSlewP	201	200	DzSlewP
DzSlewN	201	110	DzSlewN
g210	210	110	200	110	11.5515e-6
R210	210	110	Rideal	0.55e6
C210	210	110	1e-012
RX2	60	210	Rideal	0.001
DzVoutP	61	60	DzVoutP
DzVoutN	60	62	DzVoutN
DVoutP	61	63	diode
DVoutN	64	62	diode
VoutP	65	63	dc	6.404
VoutN	64	66	dc	6.512
e60	65	110	111	110	1.08
e61	66	110	112	110	1.08
g220	220	110	210	110	0.001
R220	220	110	Rideal	1000
R221	220	221	Rideal	9e3
C220	221	110	17.6839e-12
g230	230	110	220	110	0.001
R230	230	110	Rideal	1000
C230	230	110	0.0804e-12
g240	240	110	230	110	0.001
R240	240	110	Rideal	1000
C240	240	110	0.0751e-12
g245	245	110	240	110	0.001
R245	245	110	Rideal	1000
C245	245	110	0.0531e-12
g250	250	110	245	110	0.001
R250	250	110	Rideal	1000
g255	255	110	250	110	0.001
R255	255	110	Rideal	1000
g260	260	110	255	110	0.001
R260	260	110	Rideal	1000
g265	265	110	260	110	0.001
R265	265	110	Rideal	1000
g270	270	110	265	110	0.001
R270	270	110	Rideal	1000
e280	280	110	270	110	1
R280	280	285	Rideal	10
e290	290	110	285	110	1
R290	290	292	Rideal	10
L290	290	291	5305.159e-9
C290	291	292	212206.351e-12
R291	292	110	Rideal	13.929
e295	295	110	292	110	1.7179
g300	300	110	295	110	0.001
R300	300	110	Rideal	1000
e301	301	110	300	110	1
Rout	302	303	Rideal	 8
Lout	303	310	 5.6e-9
Cout	310	110	 1.3e-12
H1	301	304	Vsense1	100
Vsense1	301	302	dc	0
VIoutP	305	304	dc	16.336
VIoutN	304	306	dc	9.336
DIoutP	307	305	diode
DIoutN	306	307	diode
Rx3	307	300	Rideal	0.001
VoutP1	111	73	dc	1.685
VoutN1	74	112	dc	1.685
DVoutP1	75	73	diode
DVoutN1	74	75	diode
RX4	75	310	Rideal	0.001
FIoVcc	314	110	Vmeas8	1
Vmeas8	310	311	dc	0
R314	110	314	Rideal	1e9
DzOVcc	110	314	diode
DOVcc	102	314	diode
RX5	311	312	Rideal	0.001
FIoVee	315	110	Vmeas9	1
Vmeas9	312	313	dc	0
R315	315	110	Rideal	1e9
DzOVee	315	110	diode
DOVee	315	103	diode
S4	104	313	106	113	Switch
.model	diode	d(bv=100)
.model	Switch	vswitch(Von=2.005,Voff=1.995,ron=0.001,roff=1e6)
.model	DzVoutP	D(BV=4.3)
.model	DzVoutN	D(BV=4.3)
.model	DzSlewP	D(BV=75.79)
.model	DzSlewN	D(BV=75.79)
.model	DVnoisy	D(IS=5e-16 KF=7.07e-15)
.model	DINnoisy	D(IS=2.38e-22 KF=0.00e0)
.model	DIPnoisy	D(IS=2.38e-22 KF=0.00e0)
.model	Rideal	res(T_ABS=-273)
.ends ADA4817

.END
