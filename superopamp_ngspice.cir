* SUPEROPAMP (ngspice format)
**************************************
**  Translated from TINA to ngspice   **
**************************************

* ----------------------------------------------------------------------
* HIGH-SPEED ADA4817 MACROMODEL DEFINITION (Analog Devices Official)
* ----------------------------------------------------------------------
* Node Assignments:
*                Non-Inverting Input
*                |   Inverting Input
*                |   |   Positive supply
*                |   |   |   Negative supply
*                |   |   |   |   Output
*                |   |   |   |   |   FB (Feedback Pin)
*                |   |   |   |   |   |   PD (Power Down)
*                |   |   |   |   |   |   |
.Subckt ADA4817 100 101 102 103 104 105 106
*
***Power Supplies***
Rz1	102	1020	Rideal	1e-6
Rz2	103	1030	Rideal	1e-6
Ibias	1020	1030	dc	1.5e-3
DzPS	98	1020	diode
Iquies	1020	98	dc	17.5e-3
RS1	98	1030	1e-3
RPPull	1020	99	Rideal	1e7
RPPull2	99	1030	Rideal	1e7
e1	111	110	1020	110	1
e2	110	112	110	1030	1
e3	110	0	99	0	1
*
***Inputs***
RS2	1	100	1e-3
RS3	9	101	1e-3
VOS	1	2	dc	0
IbiasP	110	2	dc	2e-12
IbiasN	110	9	dc	2e-12
RinCMP	110	2	Rideal	500000e6
RinCMN	9	110	Rideal	500000e6
CinCMP	110	2	1.3e-12
CinCMN	9	110	1.3e-12
IOS	9	2	1e-12
RinDiff	9	2	Rideal	5000e3
CinDiff	9	2	0.3e-12
*
***Non-Inverting Input with Clamp***
g1	3	110	110	2	0.001
RInP	3	110	Rideal	1e3
RX1	40	3	Rideal	0.001
DInP	40	41	diode
DInN	42	40	diode
VinP	111	41	dc	3.26
VinN	42	112	dc	0.46
*
***Vnoise***
hVn	6	5	Vmeas1	707.10678
Vmeas1	20	110	DC	0
Vvn	21	110	dc	0.65
Dvn	21	20	DVnoisy
hVn1	6	7	Vmeas2	707.10678
Vmeas2	22	110	dc	0
Vvn1	23	110	dc	0.65
Dvn1	23	22	DVnoisy
*
***Inoise***
FnIN	9	110	Vmeas3	0.7071068
Vmeas3	51	110	dc	0
Vvn_in	50	110	dc	0.65
DnIN	50	51	DINnoisy
FnIN1	110	9	Vmeas4	0.7071068
Vmeas4	53	110	dc	0
Vvn_in1	52	110	dc	0.65
DnIN1	52	53	DINnoisy
*
FnIP	2	110	Vmeas5	0.7071068
Vmeas5	31	110	dc	0
Vvn_ip	30	110	dc	0.65
DnIP	30	31	DIPnoisy
FnIP1	110	2	Vmeas6	0.7071068
Vmeas6	33	110	dc	0
Vvn_ip1	32	110	dc	0.65
DnIP1	32	33	DIPnoisy
*
***CMRR***
RcmrrP	3	10	Rideal	1e12
RcmrrN	10	9	Rideal	1e12
g10	11	110	10	110	-1e-10
Lcmrr	11	12	1e-12
Rcmrr	12	110	Rideal	1e3
e4	5	3	11	110	1
*
***Power Down***
VPD	111	80	dc	3
VPD1	81	0	dc	2
RPD	111	106	Rideal	1e6
ePD	80	113	82	0	1
RP1	82	0	Rideal	1e3
CPD	82	0	1e-10
RS5	81	82	1e-3
CDP1	83	0	1e-12
RPD2	106	83	1e6
*
***Feedback Pin***
RF	105	104	Rideal	0.001
*
***VFB Stage***
g200	200	110	7	9	1
R200	200	110	Rideal	250
DzSlewP	201	200	DzSlewP
DzSlewN	201	110	DzSlewN
*
***Dominant Pole at 290 Hz***
g210	210	110	200	110	11.5515e-6
R210	210	110	Rideal	0.55e6
C210	210	110	1e-012
*
***Output Voltage Clamp-1***
RX2	60	210	Rideal	0.001
DzVoutP	61	60	DzVoutP
DzVoutN	60	62	DzVoutN
DVoutP	61	63	diode
DVoutN	64	62	diode
VoutP	65	63	dc	6.404
VoutN	64	66	dc	6.512
e60	65	110	111	110	1.08
e61	66	110	112	110	1.08
*
***Pole-Zero at 0.9MHz, 1MHz***
g220	220	110	210	110	0.001
R220	220	110	Rideal	1000
R221	220	221	Rideal	9e3
C220	221	110	17.6839e-12
*
***Pole at 1980MHz***
g230	230	110	220	110	0.001
R230	230	110	Rideal	1000
C230	230	110	0.0804e-12
*
***Pole at 2120MHz***
g240	240	110	230	110	0.001
R240	240	110	Rideal	1000
C240	240	110	0.0751e-12
*
***Pole at 3000MHz***
g245	245	110	240	110	0.001
R245	245	110	Rideal	1000
C245	245	110	0.0531e-12
*
***Buffer***
g250	250	110	245	110	0.001
R250	250	110	Rideal	1000
*
***Buffer***
g255	255	110	250	110	0.001
R255	255	110	Rideal	1000
*
***Buffer***
g260	260	110	255	110	0.001
R260	260	110	Rideal	1000
*
***Buffer***
g265	265	110	260	110	0.001
R265	265	110	Rideal	1000
*
***Buffer***
g270	270	110	265	110	0.001
R270	270	110	Rideal	1000
*
***Buffer***
e280	280	110	270	110	1
R280	280	285	Rideal	10
*
***Peak: f=0.15MHz, Zeta=1, Gain=4.7dB***
e290	290	110	285	110	1
R290	290	292	Rideal	10
L290	290	291	5305.159e-9
C290	291	292	212206.351e-12
R291	292	110	Rideal	13.929
e295	295	110	292	110	1.7179
*
***Output Stage***
g300	300	110	295	110	0.001
R300	300	110	Rideal	1000
e301	301	110	300	110	1
Rout	302	303	Rideal	 8
Lout	303	310	 5.6e-9
Cout	310	110	 1.3e-12
*
***Output Current Limit***
H1	301	304	Vsense1	100
Vsense1	301	302	dc	0
VIoutP	305	304	dc	16.336
VIoutN	304	306	dc	9.336
DIoutP	307	305	diode
DIoutN	306	307	diode
Rx3	307	300	Rideal	0.001
*
***Output Clamp-2***
VoutP1	111	73	dc	1.685
VoutN1	74	112	dc	1.685
DVoutP1	75	73	diode
DVoutN1	74	75	diode
RX4	75	310	Rideal	0.001
*
***Supply Currents***
FIoVcc	314	110	Vmeas8	1
Vmeas8	310	311	dc	0
R314	110	314	Rideal	1e9
DzOVcc	110	314	diode
DOVcc	102	314	diode
RX5	311	312	Rideal	0.001
FIoVee	315	110	Vmeas9	1
Vmeas9	312	313	dc	0
R315	315	110	Rideal	1e9
DzOVee	315	110	diode
DOVee	315	103	diode
*
***Output Switch***
RS4	104	313	1e-3
*
*** Common Models ***
.model	diode	d(bv=100)
.model	Switch	sw(vt=2.0 vh=0.005 ron=0.001 roff=1e6)
.model	DzVoutP	D(BV=4.3)
.model	DzVoutN	D(BV=4.3)
.model	DzSlewP	D(BV=75.79)
.model	DzSlewN	D(BV=75.79)
.model	DVnoisy	D(IS=5e-16 KF=7.07e-15)
.model	DINnoisy	D(IS=2.38e-22 KF=0.00e0)
.model	DIPnoisy	D(IS=2.38e-22 KF=0.00e0)
.model	Rideal	res(T_ABS=-273)
*
.ends ADA4817
* ----------------------------------------------------------------------

.TEMP 27

* Power Supplies
V3          cc 0 DC 20
V2          0 dd DC 20

* Input Voltage Source
* DC = 0V, AC = 1V, and 10uV peak, 10Hz sine wave for transient analysis (in-band)
Vin          in 0 DC 0 AC 1 SIN(0 10u 10)

* Circuit Netlist
C6          0 8 163N
C5          9 out 163N
C4          11 6 33N
C3          5 12 33N
C2          13 4 33N
C1          3 14 33N
R10         6 8 750
R9          8 0 10K
R8          5 9 750
R7          9 out 10K
XOP5         8 9 cc dd out out cc ADA4817
R6          12 11 500
R5          6 11 49.5K
R4          5 12 49.5K
XOP4         4 11 cc dd 6 6 cc ADA4817
XOP3         3 12 cc dd 5 5 cc ADA4817
R3          14 13 500
R2          4 13 49.5K
R1          3 14 49.5K
XOP2         in 13 cc dd 4 4 cc ADA4817
XOP1         0 14 cc dd 3 3 cc ADA4817

* Simulation Control block
.control
  * 1. DC Linearity Sweep
  dc Vin -35u 35u 0.1u
  wrdata superopamp_dc.txt v(out)

  * 2. AC Frequency Response Sweep (Bode)
  ac dec 100 1 100meg
  let gain_db = vdb(out)
  let phase_rad = ph(v(out))
  let phase_deg = phase_rad * 180 / 3.141592653589793
  wrdata superopamp_ac.txt gain_db phase_deg

  * 3. Transient Response Analysis
  * 10Hz frequency, 3 cycles = 300ms. Step size 100us.
  tran 100u 300m
  wrdata superopamp_tran.txt v(in) v(out)

  echo "=== SIMULATION COMPLETED SUCCESSFULLY ==="
.endc

.END
