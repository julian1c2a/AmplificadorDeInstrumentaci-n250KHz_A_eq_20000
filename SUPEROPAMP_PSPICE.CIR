SUPEROPAMP_PSPICE (PSpice format)
**************************************
**  This file was created by TINA   **
**         www.tina.com             **
**      (c) DesignSoft, Inc.        **
**     www.designsoftware.com       **
**************************************
.LIB "E:\TINA\EXAMPLES\SPICE\TSPICE.LIB"
.LIB "E:\TINA\SPICELIB\Operational Amplifiers.LIB"
.LIB
.TEMP 27
.AC DEC 1250 1 100MEG
.TRAN 2N 1U
.DC LIN Vin -150U 150U 30N

.OPTIONS ABSTOL=1P ITL1=150 ITL2=20 ITL4=10 TRTOL=7
.PROBE V(3,4) V(5,6) V([in]) V([out])

Vin         in 0 DC 0 AC 1 0
+ PULSE ( 0 1 0  0  0  1e19 1e20 )
V3          cc 0 20
V2          0 dd 20
C6          0 8 163N
C5          9 out 163N
C4          11 6 33N
C3          5 12 33N
C2          13 4 33N
C1          3 14 33N
R10         6 8 750
R9          8 0 10K
R8          5 9 750
R7          9 out 10K
XOP5         8 9 cc dd out StdOpamp
+ PARAMS: GAIN=200K RIN=10T ROUT=75 SLEWRATE=13MEG FPOLE1=15 FPOLE2=9.45MEG VOFFS=3M IBIAS=30P IOFFS=5P VDROPOH=1.5 VDROPOL=1.5
R6          12 11 500
R5          6 11 49.5K
R4          5 12 49.5K
XOP4         4 11 cc dd 6 StdOpamp
+ PARAMS: GAIN=200K RIN=10T ROUT=75 SLEWRATE=13MEG FPOLE1=15 FPOLE2=9.45MEG VOFFS=3M IBIAS=30P IOFFS=5P VDROPOH=1.5 VDROPOL=1.5
XOP3         3 12 cc dd 5 StdOpamp
+ PARAMS: GAIN=200K RIN=10T ROUT=75 SLEWRATE=13MEG FPOLE1=15 FPOLE2=9.45MEG VOFFS=3M IBIAS=30P IOFFS=5P VDROPOH=1.5 VDROPOL=1.5
R3          14 13 500
R2          4 13 49.5K
R1          3 14 49.5K
XOP2         in 13 cc dd 4 StdOpamp
+ PARAMS: GAIN=200K RIN=10T ROUT=75 SLEWRATE=13MEG FPOLE1=15 FPOLE2=9.45MEG VOFFS=3M IBIAS=30P IOFFS=5P VDROPOH=1.5 VDROPOL=1.5
XOP1         0 14 cc dd 3 StdOpamp
+ PARAMS: GAIN=200K RIN=10T ROUT=75 SLEWRATE=13MEG FPOLE1=15 FPOLE2=9.45MEG VOFFS=3M IBIAS=30P IOFFS=5P VDROPOH=1.5 VDROPOL=1.5

.END
